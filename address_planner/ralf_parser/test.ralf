# source ralf_parser.tcl

#puts [info vars]

field TXE {
    bits 1;
    access rw;
    reset 0;
    endian 1;
}

register L2 [1] {
        field TXE @0;
        field TXD @4 {
            bits 1;
            access rw;
            reset 0;
        }

        field Reserve_1 @5 {
            access rw;
            reset 0;
        }

        field TXD_2 @10 {
            bits 20;
            access rw;
            reset 0;
        }

        
    }


block B1 {
    register L1 @1 {
        bytes 4;
        field TXE @0;
        field TXD @4 {
            bits 1;
            access ro;
            reset 1'h1;
            attributes { NO_REG_TEST 1 }
        }
        
    }
}

block B2 {
    register L1 [1] @1 {
        field TXE @0;
        field TXD @4 {
            bits 1;
            access rw;
            reset 0;
        }

        field Reserve_1 @5 {
            access rw;
            reset 0;
        }

        field TXD_2 @10 {
            bits 20;
            access rw;
            reset 0;
        }
    }
    register L2 @9;
}


block DWC_DDRPHYA_AC1_p0 {
    bytes 2;
    register DFIMRL_p0 @'h0 {
        bytes 1;
        field DFIMRL_p0 @'h0 {
            bits 5;
            access rw;
            hard_reset 'h6;
            doc {
                This Max Read Latency CSR is to be trained to ensure the Rx-Data FIFO is not read until after all dbytes have their read data valid.
In DBYTE, this is the value, in units of DFI Clocks (DfiClk), between dfi_rddata_en and dfi_rddata_valid.
In AC, this is the value, in units of DFI Clocks (DfiClk), between generation of the Read Pointer for reading of the RxDatFifo and Writing to the FIFO.

            }
            }
        }
}

system sys1 {
    block B1 @1;
    block B2 @70000;
    block DWC_DDRPHYA_AC1_p0 @80000;
}
